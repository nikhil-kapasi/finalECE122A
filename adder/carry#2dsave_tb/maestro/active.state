ADE simulation setup
Test adder_carry-save_tb_1: adder/carry-save_tb/schematic, simulator spectre
  Models: /fs/ece/PDKs/theogarajan/Skywater130_PDK/Skywater130/sky130_release_0.0.4/libs/sky130_fd_pr_main/../../models/sky130.lib.spice[tt]
  Temperature: 27
  Analysis tran: stop=1u errpreset=liberal
  Signals: /s0, /s1, /s3, /s4, /s5, /s6, /s7, /s8, /1, /0, /sum, /cout, /VDD!, /VSS!
Run mode: Single Run, Sweeps and Corners
