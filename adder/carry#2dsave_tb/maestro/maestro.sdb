ADE simulation setup
Run mode: Single Run, Sweeps and Corners
Tests:
  adder_carry-save_tb_1: adder/carry-save_tb/schematic, simulator spectre
    Outputs: /s0; /s1; /s3; /s4; /s5; /s6; /s7; /s8; /1; /0; /sum; /cout; /VDD!; /VSS!
